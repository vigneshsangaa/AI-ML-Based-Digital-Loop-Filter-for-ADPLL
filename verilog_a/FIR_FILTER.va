// ============================================================
//  FIR Filter - NN3 (Balanced) Coefficients
//  Verilog-A conversion for Cadence Virtuoso + Spectre
//
//  Exact match to RTL:
//    N_TAPS  = 25   (filter order = 25)
//    N2      =  4   (input: 4-bit signed TDC, range -8 to +7)
//    N_COEFF = 12   (coefficient Q1.12, SCALE=2047)
//    N3      =  9   (output width after shift)
//    SHIFT   =  9   (right shift on accumulator output)
//
//  Ports (bit-level, matching schematic pin-out):
//    input_data0..3   : 4-bit signed phase error from TDC
//    CLK              : Reference clock (FREF)
//    RST              : Active-high reset
//    Enable           : Filter enable signal
//    output_data0..8  : 9-bit UNSIGNED DCO control word (0..511)
//    SamplT           : samples[0] monitor tap (debug)
// ============================================================

`include "constants.vams"
`include "disciplines.vams"

module FIR_NN3 (input_data0, input_data1, input_data2, input_data3,
                CLK, RST, Enable,
                output_data0, output_data1, output_data2, output_data3,
                output_data4, output_data5, output_data6, output_data7,
                output_data8,
                SamplT, VDD, VSS);

    //  Port Declarations
    input  input_data0, input_data1, input_data2, input_data3;
    input  CLK;             // Reference clock FREF
    input  RST;             // Active-high synchronous reset
    input  Enable;          // Filter enable

    // 9-bit output (bit0 to bit8)
    output output_data0, output_data1, output_data2, output_data3;
    output output_data4, output_data5, output_data6, output_data7;
    output output_data8;
    output SamplT;          // Debug: samples[0] monitor
    input  VDD, VSS;

    electrical input_data0, input_data1, input_data2, input_data3;
    electrical CLK, RST, Enable;
    electrical output_data0, output_data1, output_data2, output_data3;
    electrical output_data4, output_data5, output_data6, output_data7;
    electrical output_data8;
    electrical SamplT;
    electrical VDD, VSS;

    //  Parameters (Strict 9-bit configuration)
    parameter real VDD_val    = 1.8;
    parameter real clk_thresh = 0.9;
    parameter real rst_thresh = 0.9;
    parameter real en_thresh  = 0.9;
    parameter real t_trans    = 200p;

    parameter integer N_TAPS  = 25;
    parameter integer N2      = 4;
    parameter integer N_COEFF = 12;
    parameter integer N3      = 9;    // 9-bit output width
    parameter integer SHIFT   = 9;    // Right shift on accumulator (divide by 512)

    // 9-bit unsigned bounds: [0, 511]
    parameter real DCO_CENTER = 256.0;
    parameter real DCO_MIN    = 0.0;
    parameter real DCO_MAX    = 511.0;

    //  Arrays
    real b [0:24];
    real samples [0:24];

    //  Internal Math Signals
    real output_data_reg;
    real out_shifted;
    real out_signed;
    real out_unsigned;
    real sample_t_val;
    real in_val;
    integer dco_int;

    // 9 bits tracking array (indices 0 to 8)
    integer out_bit[0:8];
    integer i;

    //  Initialization
    analog initial begin
        // NN3 Balanced Coefficients
        b[ 0] = -41.0;  b[ 1] = -80.0;  b[ 2] = -115.0; b[ 3] = -131.0; b[ 4] = -113.0;
        b[ 5] = -56.0;  b[ 6] =  37.0;  b[ 7] =  153.0; b[ 8] =  267.0; b[ 9] =  355.0;
        b[10] =  398.0; b[11] =  386.0; b[12] =  326.0; b[13] =  233.0; b[14] =  131.0;
        b[15] =  44.0;  b[16] = -11.0;  b[17] = -30.0;  b[18] = -18.0;  b[19] =  13.0;
        b[20] =  45.0;  b[21] =  67.0;  b[22] =  71.0;  b[23] =  59.0;  b[24] =  37.0;

        for (i = 0; i < N_TAPS; i = i + 1) begin
            samples[i] = 0.0;
        end

        output_data_reg = 0.0;
        out_shifted     = 0.0;
        out_signed      = 0.0;
        out_unsigned    = DCO_CENTER;
        sample_t_val    = 0.0;

        for (i = 0; i < 9; i = i + 1) out_bit[i] = 0;
    end

    //  Main Analog Block
    analog begin

        // Triggered on rising edge of CLK
        @(cross(V(CLK) - clk_thresh, +1, 10p)) begin

            // Synchronous Active-High Reset
            if (V(RST) > rst_thresh) begin
                for (i = 0; i < N_TAPS; i = i + 1) samples[i] = 0.0;
                output_data_reg = 0.0;
                out_shifted     = 0.0;
                out_signed      = 0.0;
                out_unsigned    = DCO_CENTER;
                sample_t_val    = 0.0;
                for (i = 0; i < 9; i = i + 1) out_bit[i] = 0;
            end

            // Filter Update Cycle
            else if (V(Enable) > en_thresh) begin

                // Step 1: Shift delay line
                for (i = N_TAPS-1; i > 0; i = i - 1) begin
                    samples[i] = samples[i-1];
                end

                // Step 2: Extract signed 4-bit TDC value
                in_val = (V(input_data0, VSS) > clk_thresh ? 1.0 : 0.0)
                       + (V(input_data1, VSS) > clk_thresh ? 2.0 : 0.0)
                       + (V(input_data2, VSS) > clk_thresh ? 4.0 : 0.0)
                       + (V(input_data3, VSS) > clk_thresh ? 8.0 : 0.0);

                if (V(input_data3, VSS) > clk_thresh) // MSB Sign Extension
                    in_val = in_val - 16.0;

                samples[0] = in_val;

                // Step 3: Fixed Convolution Loop (Linearly aligned)
                output_data_reg = 0.0;
                for (i = 0; i < N_TAPS; i = i + 1) begin
                    output_data_reg = output_data_reg + (b[i] * samples[i]);
                end

                // Step 4: Arithmetic bit shift down (>> 9 is division by 512)
                out_shifted = floor(output_data_reg / 512.0);

                // Step 5: 9-bit Signed Masking wrapping
                out_signed = out_shifted - floor(out_shifted / 512.0) * 512.0;
                if (out_signed >= 256.0) out_signed = out_signed - 512.0;

                // Step 6: Center-offset and clamp to 9-bit Unsigned range [0..511]
                out_unsigned = out_signed + DCO_CENTER;
                if (out_unsigned > DCO_MAX)       out_unsigned = DCO_MAX;
                else if (out_unsigned < DCO_MIN)  out_unsigned = DCO_MIN;

                // Step 7: Decompose unsigned integer value into 9 standalone bits
                dco_int = out_unsigned;
                for (i = 0; i < 9; i = i + 1) begin
                    out_bit[i] = dco_int % 2;
                    dco_int = dco_int / 2;
                end

                sample_t_val = samples[0];
            end
        end

        //  Continuous Output Electrical Bus Drivers
        V(output_data0, VSS) <+ transition(out_bit[0] ? VDD_val : 0.0, 0, t_trans);
        V(output_data1, VSS) <+ transition(out_bit[1] ? VDD_val : 0.0, 0, t_trans);
        V(output_data2, VSS) <+ transition(out_bit[2] ? VDD_val : 0.0, 0, t_trans);
        V(output_data3, VSS) <+ transition(out_bit[3] ? VDD_val : 0.0, 0, t_trans);
        V(output_data4, VSS) <+ transition(out_bit[4] ? VDD_val : 0.0, 0, t_trans);
        V(output_data5, VSS) <+ transition(out_bit[5] ? VDD_val : 0.0, 0, t_trans);
        V(output_data6, VSS) <+ transition(out_bit[6] ? VDD_val : 0.0, 0, t_trans);
        V(output_data7, VSS) <+ transition(out_bit[7] ? VDD_val : 0.0, 0, t_trans);
        V(output_data8, VSS) <+ transition(out_bit[8] ? VDD_val : 0.0, 0, t_trans);

        V(SamplT,        VSS) <+ transition(sample_t_val,               0, t_trans);
    end

endmodule
